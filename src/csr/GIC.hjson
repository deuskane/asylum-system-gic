{
    name      : "GIC",
    width     : 8,
    desc      : "CSR for GIC"
    interface : "pbi"

    registers : [

        {
            name         : "isr",
            address      : "x0",
            desc         : "Interruption Status Register",
            swaccess     : "rw1c",
            hwaccess     : "rw",
            hwtype       : "reg",

            fields: [
                {
                    name: "value",
                    bits: "7:0",
                    desc: "0: interrupt is inactive, 1: interrupt is active"
                },
            ]
        },

        {
            name         : "imr",
            address      : "x1",
            desc         : "Interruption Mask Register",
            swaccess     : "rw",
            hwaccess     : "ro",
            hwtype       : "reg",

            fields: [
                {
                    name: "enable",
                    bits: "7:0",
		    init: "x00",
                    desc: "0: interrupt is disable, 1: interrupt is enable"
                },
            ]
        },

]
}
